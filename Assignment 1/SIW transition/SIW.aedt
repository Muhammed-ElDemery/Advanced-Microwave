# Ansys Electronics Desktop project, version 2025.2
materials:
  vacuum: permittivity=1
  Material1: permittivity=3.48 dielectric_loss_tangent=0.003
  copper: permeability=0.999991 conductivity=58000000
  air: permittivity=1.0006 permeability=1.0000004

design HFSSDesign1 (HFSS, HFSS Terminal Network, model units mm)
variables:
  W_gnd = 10.5mm
  L_gnd = 20mm
  copper_height = 0.02mm
  sub_height = 0.762mm
  W_micro = 1.8mm
  via_rad = 0.3mm
  spacing = 0.5mm
  pitch_spacing = 0.76mm
  W_tap = 4.1mm
  L_tap = 4mm
  no_cyl = 13
geometry:
  Substrate [Material1] = box(corner=(-W_gnd/2, -L_gnd/2, copper_height), size=(W_gnd, L_gnd, sub_height))
  GND [copper] = box(corner=(-W_gnd/2, -L_gnd/2, 0mm), size=(W_gnd, L_gnd, copper_height))
  SIW_trace [copper] = box(corner=(-W_gnd/2, -L_gnd/4, copper_height+sub_height), size=(W_gnd, L_gnd/2, copper_height))
  mlin = box(corner=(-W_micro/2, L_gnd/4+L_tap, copper_height+sub_height), size=(W_micro, L_gnd/4-L_tap, copper_height))
  Cylinder1 = cylinder(axis=Z, base_centre=(-W_gnd/2+spacing+via_rad, -L_gnd/4+0.05mm+via_rad, copper_height), radius=via_rad, height=sub_height)
  Cylinder1.duplicate_along_line(step=(0mm, pitch_spacing, 0mm), total=no_cyl, attached)
  Cylinder2 = cylinder(axis=Z, base_centre=(W_gnd/2-spacing-via_rad, -L_gnd/4+0.05mm+via_rad, copper_height), radius=via_rad, height=sub_height)
  Cylinder2.duplicate_along_line(step=(0mm, pitch_spacing, 0mm), total=no_cyl, attached)
  Cylinder1_1 = Cylinder1.copy()
  Cylinder2_1 = Cylinder2.copy()
  Substrate.subtract(Cylinder1_1, Cylinder2_1)
  mlin1 = box(corner=(-W_micro/2, -L_gnd/2, copper_height+sub_height), size=(W_micro, L_gnd/4-L_tap, copper_height))
  Polyline1 = polyline((-W_tap/2, L_gnd/4, copper_height+sub_height+copper_height) (W_tap/2, L_gnd/4, copper_height+sub_height+copper_height))
  Polyline2 = polyline((-W_micro/2, L_gnd/4+L_tap, copper_height+sub_height+copper_height) (W_micro/2, L_gnd/4+L_tap, copper_height+sub_height+copper_height))
  Polyline2.connect(Polyline1)
  Polyline2.thicken(0.02mm)
  mlin.unite(Polyline2)
  Polyline3 = polyline((-W_micro/2, -L_gnd/4-L_tap, copper_height+sub_height) (W_micro/2, -L_gnd/4-L_tap, copper_height+sub_height))
  Polyline4 = polyline((-W_tap/2, -L_gnd/4, copper_height+sub_height) (W_tap/2, -L_gnd/4, copper_height+sub_height))
  Polyline3.connect(Polyline4)
  Polyline3.thicken(0.02mm)
  mlin1.unite(Polyline3)
  RadBox [air] = box(corner=(-W_gnd/2-10mm, -L_gnd/2, 0mm), size=(W_gnd+20mm, L_gnd, 10mm))
  Rectangle1 = rectangle(corner=(-3*sub_height, -L_gnd/2, 0mm), z_size=5*sub_height, x_size=6*sub_height)
  Rectangle2 = rectangle(corner=(-3*sub_height, L_gnd/2, 0mm), z_size=5*sub_height, x_size=6*sub_height)
  GND.unite(Cylinder1, Cylinder2)
  SIW_trace.unite(mlin1, mlin)
boundaries and excitations:
  SIW_trace_T1: Terminal port=1 Faces=SIW_trace.face(at (0, -10, 0.792)) TerminalResistance=50ohm
  SIW_trace_T2: Terminal port=2 Faces=SIW_trace.face(at (0, 10, 0.792)) TerminalResistance=50ohm
  1: Wave Port Faces=Rectangle1.face WavePortType=Terminal NumModes=1 SpecifiedWaveDirectionFlip
  2: Wave Port Faces=Rectangle2.face WavePortType=Terminal NumModes=1
  reference conductors: GND
setups:
  Setup1: HfssDriven Frequency=12GHz MaxDeltaS=0.02 MaximumPasses=20 MinimumPasses=1 MinimumConvergedPasses=1 PercentRefinement=30 BasisOrder=1 PortAccuracy=2 DrivenSolverType="Direct Solver"
    sweep Sweep: 5GHz to 25GHz step 0.125GHz; Type=Interpolating InterpTolerance=0.5 InterpMaxSolns=250 PassivityErrorTolerance=0.0001
source amplitudes:
  1:1: 1V 0deg
  2:1: 0V 0deg
reports:
  Terminal S Parameter Plot2: dB(St(SIW_trace_T2,SIW_trace_T1)) vs Freq on Setup1 : Sweep; markers MX1 at x=1.25e+10, MX2 at x=1.75e+10
  Terminal S Parameter Plot3: dB(St(SIW_trace_T1,SIW_trace_T1)) vs Freq on Setup1 : Sweep
